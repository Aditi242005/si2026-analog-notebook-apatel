** sch_path: /foss/designs/apatel/SI-2026-AnalogIC/SI-2026-AnalogIC/ngspice/getStarted/SI-2026-AnalogIC/ngspice/getStarted/TB_mic_para.sch
**.subckt TB_mic_para
Vmic vin GND 0 AC=0
Rmic vin1 vin 380 m=1
C1 vin2 vin1 4.7u m=1
R2 viom vin2 4.7k m=1
E1 vout GND vref viom 10e5
V2 Vbat GND 2.5 AC=1
R3 vout viom 300k m=1
C2 vout viom 27p m=1
R4 vref Vbat 10k m=1
R5 GND vref 10k m=1
C3 vref GND 1u m=1
C4 vout GND 1p m=1
**** begin user architecture code

.param temp=27
.control
save all
op
ac dec 100 1 100meg

let voutdb = vdb(vout)
let voutabs = abs(vout)

meas ac vout_1k find voutabs at=1k
meas ac voutdb_1k find voutdb at=1k

meas ac psg_1k find vdb(vout) at=1k

let voutm3db = voutdb_1k - 3.0
meas ac fp3db WHEN voutdb=voutm3db fall=last
meas ac fz3db WHEN voutdb=voutm3db rise=1
plot vdb(vout)
plot phase(vout)

.endc

**** end user architecture code
**.ends
.GLOBAL GND
.end
